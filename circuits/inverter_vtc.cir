* CMOS Inverter VTC Simulation
.include /path/to/your/tech_models.lib  ; Optional: use real PDK models
; If not available, define simple models:

.model nmos_mod nmos (vto=0.7 kp=120u lambda=0.02)
.model pmos_mod pmos (vto=-0.7 kp=40u lambda=0.02)

* Circuit
VDD vdd 0 DC 3.3
Vin in 0 DC 0
M1 out in 0 0 nmos_mod W=1u L=0.5u
M2 out in vdd vdd pmos_mod W=2u L=0.5u

* DC sweep
.control
  dc Vin 0 3.3 0.01
  let gain = deriv(v(out))/deriv(v(in))
  plot v(out) v(in)
  plot gain
.endc
.end
